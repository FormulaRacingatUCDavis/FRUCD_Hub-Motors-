# Ansys Electronics Desktop project, version 2024.2
materials:
  vacuum: permittivity=1

design Maxwell3DDesign1 (Maxwell 3D, Magnetostatic, model units in)
geometry:
  CoilHousing_1, Coil_1, CoilHousing_6, Coil_6, CoilHousing_2, Coil_2, CoilHousing_4, Coil_4, CoilHousing_3, Coil_3, StatorCoilHousing, CoilHousing_7, Coil_7, CoilHousing_9, Coil_9, CoilHousing_8, Coil_8, CoilHousing_5, Coil_5, PermanentMagnet_T1, PermanentMagnet_T8, Rotor_T, PermanentMagnet_T7, PermanentMagnet_T12, PermanentMagnet_T9, PermanentMagnet_T3, PermanentMagnet_T5, PermanentMagnet_T6, PermanentMagnet_T2, PermanentMagnet_T4, PermanentMagnet_T11, PermanentMagnet_T10, PermanentMagnet_B1, PermanentMagnet_B6, Rotor_B, PermanentMagnet_B7, PermanentMagnet_B2, PermanentMagnet_B5, PermanentMagnet_B11, PermanentMagnet_B9, PermanentMagnet_B8, PermanentMagnet_B12, PermanentMagnet_B10, PermanentMagnet_B3, PermanentMagnet_B4 = imported_body(C:\Users\athar\OneDrive\Desktop\RotorStatorAssembly_STEP214.STEP)
  [CoilHousing_1, Coil_1, CoilHousing_6, Coil_6, CoilHousing_2, Coil_2, CoilHousing_4, Coil_4, CoilHousing_3, Coil_3, StatorCoilHousing, CoilHousing_7, Coil_7, CoilHousing_9, Coil_9, CoilHousing_8, Coil_8, CoilHousing_5, Coil_5, PermanentMagnet_T1, PermanentMagnet_T8, Rotor_T, PermanentMagnet_T7, PermanentMagnet_T12, PermanentMagnet_T9, PermanentMagnet_T3, PermanentMagnet_T5, PermanentMagnet_T6, PermanentMagnet_T2, PermanentMagnet_T4, PermanentMagnet_T11, PermanentMagnet_T10, PermanentMagnet_B1, PermanentMagnet_B6, Rotor_B, PermanentMagnet_B7, PermanentMagnet_B2, PermanentMagnet_B5, PermanentMagnet_B11, PermanentMagnet_B9, PermanentMagnet_B8, PermanentMagnet_B12, PermanentMagnet_B10, PermanentMagnet_B3, PermanentMagnet_B4].move(0in, -7in, 0in)
  [CoilHousing_1, Coil_1, CoilHousing_6, Coil_6, CoilHousing_2, Coil_2, CoilHousing_4, Coil_4, CoilHousing_3, Coil_3, StatorCoilHousing, CoilHousing_7, Coil_7, CoilHousing_9, Coil_9, CoilHousing_8, Coil_8, CoilHousing_5, Coil_5, PermanentMagnet_T1, PermanentMagnet_T8, Rotor_T, PermanentMagnet_T7, PermanentMagnet_T12, PermanentMagnet_T9, PermanentMagnet_T3, PermanentMagnet_T5, PermanentMagnet_T6, PermanentMagnet_T2, PermanentMagnet_T4, PermanentMagnet_T11, PermanentMagnet_T10, PermanentMagnet_B1, PermanentMagnet_B6, Rotor_B, PermanentMagnet_B7, PermanentMagnet_B2, PermanentMagnet_B5, PermanentMagnet_B11, PermanentMagnet_B9, PermanentMagnet_B8, PermanentMagnet_B12, PermanentMagnet_B10, PermanentMagnet_B3, PermanentMagnet_B4].rotate(axis=X, angle=90deg)
  [CoilHousing_1, Coil_1, CoilHousing_6, Coil_6, CoilHousing_2, Coil_2, CoilHousing_4, Coil_4, CoilHousing_3, Coil_3, StatorCoilHousing, CoilHousing_7, Coil_7, CoilHousing_9, Coil_9, CoilHousing_8, Coil_8, CoilHousing_5, Coil_5, PermanentMagnet_T1, PermanentMagnet_T8, Rotor_T, PermanentMagnet_T7, PermanentMagnet_T12, PermanentMagnet_T9, PermanentMagnet_T3, PermanentMagnet_T5, PermanentMagnet_T6, PermanentMagnet_T2, PermanentMagnet_T4, PermanentMagnet_T11, PermanentMagnet_T10, PermanentMagnet_B1, PermanentMagnet_B6, Rotor_B, PermanentMagnet_B7, PermanentMagnet_B2, PermanentMagnet_B5, PermanentMagnet_B11, PermanentMagnet_B9, PermanentMagnet_B8, PermanentMagnet_B12, PermanentMagnet_B10, PermanentMagnet_B3, PermanentMagnet_B4].move(-4.0833079in, 11.362795in, 1.5199456in)
  [CoilHousing_1, Coil_1, CoilHousing_6, Coil_6, CoilHousing_2, Coil_2, CoilHousing_4, Coil_4, CoilHousing_3, Coil_3, StatorCoilHousing, CoilHousing_7, Coil_7, CoilHousing_9, Coil_9, CoilHousing_8, Coil_8, CoilHousing_5, Coil_5, PermanentMagnet_T1, PermanentMagnet_T8, Rotor_T, PermanentMagnet_T7, PermanentMagnet_T12, PermanentMagnet_T9, PermanentMagnet_T3, PermanentMagnet_T5, PermanentMagnet_T6, PermanentMagnet_T2, PermanentMagnet_T4, PermanentMagnet_T11, PermanentMagnet_T10, PermanentMagnet_B1, PermanentMagnet_B6, Rotor_B, PermanentMagnet_B7, PermanentMagnet_B2, PermanentMagnet_B5, PermanentMagnet_B11, PermanentMagnet_B9, PermanentMagnet_B8, PermanentMagnet_B12, PermanentMagnet_B10, PermanentMagnet_B3, PermanentMagnet_B4].move(0in, -4in, 1.1in)
  group RotorStatorAssembly_STEP214 = CoilHousing_1, CoilHousing_6, CoilHousing_2, CoilHousing_4, CoilHousing_3, StatorCoilHousing, CoilHousing_7, CoilHousing_9, CoilHousing_8, CoilHousing_5, Rotor_T, Rotor_B
  group Coil_Group = Coil_1, Coil_6, Coil_2, Coil_4, Coil_3, Coil_7, Coil_9, Coil_8, Coil_5
  group PermanentMagnet_B_Group = PermanentMagnet_B1, PermanentMagnet_B6, PermanentMagnet_B7, PermanentMagnet_B2, PermanentMagnet_B5, PermanentMagnet_B11, PermanentMagnet_B9, PermanentMagnet_B8, PermanentMagnet_B12, PermanentMagnet_B10, PermanentMagnet_B3, PermanentMagnet_B4
  group PermanentMagnet_T_Group = PermanentMagnet_T1, PermanentMagnet_T8, PermanentMagnet_T7, PermanentMagnet_T12, PermanentMagnet_T9, PermanentMagnet_T3, PermanentMagnet_T5, PermanentMagnet_T6, PermanentMagnet_T2, PermanentMagnet_T4, PermanentMagnet_T11, PermanentMagnet_T10
mesh:
  initial mesh: GlobalCurvilinear{Apply}
